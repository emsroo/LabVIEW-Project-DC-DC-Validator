# Ansys Electronics Desktop project, version 2023.2

design TwinBuilder1 (Twin Builder)
components:
  CONST2 = CONST(CONST=0)
  TRAPEZ1 = TRAPEZ(AMPL=0.5 PERIO=0 PWIDTH=10ms TFALL=100us TPERIO=0.0102s TRISE=100us)
  CONST1 = CONST(CONST=0)
  TRAPEZ2 = TRAPEZ(AMPL=1 PERIO=0 PWIDTH=10ms TFALL=100us TPERIO=0.0102s TRISE=100us)
  MechanicalData1 = file1(ComponentDataType=MechanicalData name=file1 filename=$PROJECTDIR\file.spm numberofports=0 LinkParams=5 LinkPar0="loadV001 2 0 0 1" LinkPar1="loadV002 2 0 0 1" LinkPar2="m1 2 0 1 1" LinkPar3="m2 2 0 1 1" LinkPar4="InitialVals 3 7 0 0" loadV001=TRAPEZ1.VAL loadV002=CONST2.VAL m1=0 m2=0)
  MechanicalData2 = file1(ComponentDataType=MechanicalData name=file1 filename=$PROJECTDIR\file.spm numberofports=0 LinkParams=5 LinkPar0="loadV001 2 0 0 1" LinkPar1="loadV002 2 0 0 1" LinkPar2="m1 2 0 1 1" LinkPar3="m2 2 0 1 1" LinkPar4="InitialVals 3 7 0 0" loadV001=CONST1.VAL loadV002=TRAPEZ2.VAL m1=0 m2=0)
nets:
  net_1: MechanicalData1.loadV001, TRAPEZ1.VAL
  net_2: MechanicalData1.loadV002, CONST2.VAL
  net_3: CONST1.VAL, MechanicalData2.loadV001
  net_4: MechanicalData2.loadV002, TRAPEZ2.VAL
setups:
  TR: TransientData(20ms, 0.1us, 10us, false, "")
reports:
  XY Stacked Plot 1: MechanicalData1.m1, TRAPEZ1.VAL vs Time on TR : TR; markers m1 at 10283300ns, m2 at 12903300ns
  XY Stacked Plot 2: TRAPEZ2.VAL, MechanicalData2.m1, MechanicalData2.m2 vs Time on TR : TR; markers m1 at 10.2933ms, m2 at 10.2933ms, m3 at 8.7531ms, m4 at 8.9531ms, m5 at 10433300ns, m6 at 13053300ns
  XY Stacked Plot 3: MechanicalData1.m1, TRAPEZ1.VAL vs Time on TR : TR; markers m1 at 10.2833ms, m2 at 12.9133ms

design TwinBuilder2 (Twin Builder)
components:
  CONST2 = CONST(CONST=0)
  TRAPEZ1 = TRAPEZ(AMPL=1 PERIO=0 PWIDTH=10ms TFALL=100us TPERIO=0.0102s TRISE=100us)
  MechanicalData1 = file1(ComponentDataType=MechanicalData name=file1 filename=$PROJECTDIR\file.spm numberofports=0 LinkParams=5 LinkPar0="loadV001 2 0 0 1" LinkPar1="loadV002 2 0 0 1" LinkPar2="m1 2 0 1 1" LinkPar3="m2 2 0 1 1" LinkPar4="InitialVals 3 7 0 0" loadV001=CONST2.VAL loadV002=TRAPEZ1.VAL m1=0 m2=0)
nets:
  net_2: CONST2.VAL, MechanicalData1.loadV001
  net_4: TRAPEZ1.VAL, MechanicalData1.loadV002
setups:
  TR: TransientData(20ms, 0.1us, 10us, false, "")
reports:
  XY Stacked Plot 1: MechanicalData1.m1, TRAPEZ1.VAL vs Time on TR : TR; markers m1 at 10283300ns, m2 at 12903300ns
